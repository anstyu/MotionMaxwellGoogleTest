# Ansys Electronics Desktop project, version 2023.1
materials:
  vacuum: permittivity=1
  NdFe30: permittivity=1 permeability=1.044573 conductivity=625000 magnetic_coercivity{Magnitude=-838000A_per_meter DirComp1=1 DirComp2=0 DirComp3=0} lande_g_factor=2
  iron: permeability=4000 conductivity=10300000

design Maxwell3DDesign1 (Maxwell 3D, Magnetostatic, model units mm)
variables:
  Magnet1_Phi = 0rad
  Magnet1_Psi = 0rad
  Magnet1_Theta = 0rad
  Magnet1_X = 0meter
  Magnet1_Y = 0.034122meter
  Magnet1_Z = 0meter
  Magnet2_Phi = 0rad
  Magnet2_Psi = 0rad
  Magnet2_Theta = 0rad
  Magnet2_X = 0meter
  Magnet2_Y = 0meter
  Magnet2_Z = 0meter
geometry:
  coordinate_system Obj_CS_Magnet1 = origin=(Magnet1_X, Magnet1_Y, Magnet1_Z) Euler Angle ZYZ phi=Magnet1_Phi theta=Magnet1_Theta psi=Magnet1_Phi
  coordinate_system Mag_CS_Magnet1 = origin=(0meter, 0meter, 0meter) Euler Angle ZYZ phi=0rad theta=0rad psi=0rad in Obj_CS_Magnet1
  Magnet1 [NdFe30, oriented by Mag_CS_Magnet1] = imported_body(E:\MotionMaxwellCoupling\TestResults\DLL_SenarioTest1\geometry2.sab) in Obj_CS_Magnet1
  Iron_Under [iron] = imported_body(E:\MotionMaxwellCoupling\TestResults\DLL_SenarioTest1\geometry2.sab)
  Container1 [vacuum] = imported_body(E:\MotionMaxwellCoupling\TestResults\DLL_SenarioTest1\geometry2.sab) in Obj_CS_Magnet1
  coordinate_system Obj_CS_Magnet2 = origin=(Magnet2_X, Magnet2_Y, Magnet2_Z) Euler Angle ZYZ phi=Magnet2_Phi theta=Magnet2_Theta psi=Magnet2_Phi
  coordinate_system Mag_CS_Magnet2 = origin=(0meter, 0meter, 0meter) Euler Angle ZYZ phi=0rad theta=0rad psi=0rad in Obj_CS_Magnet2
  Magnet2 [NdFe30, oriented by Mag_CS_Magnet2] = imported_body(E:\MotionMaxwellCoupling\TestResults\DLL_SenarioTest1\geometry2.sab) in Obj_CS_Magnet2
  Container2 [vacuum] = imported_body(E:\MotionMaxwellCoupling\TestResults\DLL_SenarioTest1\geometry2.sab) in Obj_CS_Magnet2
  OuterContainer, Region [vacuum] = imported_body(E:\MotionMaxwellCoupling\TestResults\DLL_SenarioTest1\geometry2.sab)
  Magnet1.move(0meter, -0.034122meter, 0meter) in Obj_CS_Magnet1
  Container1.move(0meter, -0.034122meter, 0meter) in Obj_CS_Magnet2
parameters:
  Force_Magnet1: Force Reference_CS=Obj_CS_Magnet1 Is_Virtual=true Objects=Magnet1
  Torque_Magnet1_X: Torque Is_Virtual=true Coordinate_System=Obj_CS_Magnet1 Axis=X Is_Positive=true Objects=Magnet1
  Torque_Magnet1_Y: Torque Is_Virtual=true Coordinate_System=Obj_CS_Magnet1 Axis=Y Is_Positive=true Objects=Magnet1
  Torque_Magnet1_Z: Torque Is_Virtual=true Coordinate_System=Obj_CS_Magnet1 Axis=Z Is_Positive=true Objects=Magnet1
  Force_Magnet2: Force Reference_CS=Obj_CS_Magnet2 Is_Virtual=true Objects=Magnet2
  Torque_Magnet2_X: Torque Is_Virtual=true Coordinate_System=Obj_CS_Magnet2 Axis=X Is_Positive=true Objects=Magnet2
  Torque_Magnet2_Y: Torque Is_Virtual=true Coordinate_System=Obj_CS_Magnet2 Axis=Y Is_Positive=true Objects=Magnet2
  Torque_Magnet2_Z: Torque Is_Virtual=true Coordinate_System=Obj_CS_Magnet2 Axis=Z Is_Positive=true Objects=Magnet2
mesh:
  initial mesh: GlobalCurvilinear{Apply}
setups:
  Setup1: Magnetostatic MaximumPasses=2 MinimumPasses=2 MinimumConvergedPasses=1 PercentRefinement=30 PercentError=1 NonLinearResidual=0.001
output variables:
  Force_Magnet1_X = Force_Magnet1.Force_x
  Force_Magnet1_Y = Force_Magnet1.Force_y
  Force_Magnet1_Z = Force_Magnet1.Force_z
  Torque_Magnet1_X = Torque_Magnet1_X.Torque
  Torque_Magnet1_Y = Torque_Magnet1_Y.Torque
  Torque_Magnet1_Z = Torque_Magnet1_Z.Torque
  Force_Magnet2_X = Force_Magnet2.Force_x
  Force_Magnet2_Y = Force_Magnet2.Force_y
  Force_Magnet2_Z = Force_Magnet2.Force_z
  Torque_Magnet2_X = Torque_Magnet2_X.Torque
  Torque_Magnet2_Y = Torque_Magnet2_Y.Torque
  Torque_Magnet2_Z = Torque_Magnet2_Z.Torque
