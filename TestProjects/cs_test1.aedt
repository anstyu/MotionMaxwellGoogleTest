# Ansys Electronics Desktop project, version 2023.1
materials:
  vacuum: permittivity=1

design Maxwell3DDesign1 (Maxwell 3D, Magnetostatic, model units mm)
geometry:
  Box1 [vacuum] = box(corner=(1meter, 2meter, 3meter), size=(1meter, 1meter, 1meter))
mesh:
  initial mesh: GlobalCurvilinear{Apply}
