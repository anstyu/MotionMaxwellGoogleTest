# Ansys Electronics Desktop project, version 2023.1
materials:
  vacuum: permittivity=1

design Maxwell3DDesign1 (Maxwell 3D, Magnetostatic, model units mm)
geometry:
  Magnet1 [NdFe30] = imported_body(E:\MotionMaxwellCoupling\TestProjects\geometry2.sab)
  Iron_Under [iron] = imported_body(E:\MotionMaxwellCoupling\TestProjects\geometry2.sab)
  Container1 [vacuum] = imported_body(E:\MotionMaxwellCoupling\TestProjects\geometry2.sab)
  Magnet2 [NdFe30] = imported_body(E:\MotionMaxwellCoupling\TestProjects\geometry2.sab)
  Container2, OuterContainer, Region [vacuum] = imported_body(E:\MotionMaxwellCoupling\TestProjects\geometry2.sab)
  group geometry2 = Magnet1, Iron_Under, Container1, Magnet2, Container2, OuterContainer, Region
mesh:
  initial mesh: GlobalCurvilinear{Apply}
